*** SPICE deck for cell simulations_glitch{sch} from library Lab5
*** Created on Wed Oct 21, 2026 22:41:42
*** Last revised on Fri Nov 06, 2026 10:05:08
*** Written on Fri Nov 06, 2026 10:09:39 by Electric VLSI Design System, version 9.08
*** Layout tech: mocmos, foundry MOSIS
*** UC SPICE *** , MIN_RESIST 4.0, MIN_CAPAC 0.1FF

*** SUBCIRCUIT Lab5__XOR_2 FROM CELL XOR_2{sch}
.SUBCKT Lab5__XOR_2 A B Y
** GLOBAL gnd
** GLOBAL vdd
Mnmos@0 notA_output A vdd vdd PMOS L=0.6U W=1.8U
Mnmos@1 notA_output A gnd gnd NMOS L=0.6U W=1.8U
Mnmos@2 notB_output B vdd vdd PMOS L=0.6U W=1.8U
Mnmos@3 notB_output B gnd gnd NMOS L=0.6U W=1.8U
Mnmos@4 net@25 notB_output vdd vdd PMOS L=0.6U W=1.8U
Mnmos@5 Y A net@25 vdd PMOS L=0.6U W=1.8U
Mnmos@6 net@26 B vdd vdd PMOS L=0.6U W=1.8U
Mnmos@7 Y notA_output net@26 vdd PMOS L=0.6U W=1.8U
Mnmos@8 Y A net@27 gnd NMOS L=0.6U W=1.8U
Mnmos@9 net@27 B gnd gnd NMOS L=0.6U W=1.8U
Mnmos@10 Y notA_output net@28 gnd NMOS L=0.6U W=1.8U
Mnmos@11 net@28 notB_output gnd gnd NMOS L=0.6U W=1.8U
.ENDS Lab5__XOR_2

.global gnd vdd

*** TOP LEVEL CELL: simulations_glitch{sch}
XXOR_2@0 ga gb gy Lab5__XOR_2

* Spice Code nodes in cell cell 'simulations_glitch{sch}'
vdd vdd 0 DC 5
vga ga 0 pulse(0v 5v 10n 1n 1n 20n 40n)
vgb gb 0 pulse(0v 5v 12n 1n 1n 20n 40n)
.tran 0 40n 0 20p
.include C5_models.txt
.END
