*** SPICE deck for cell daq_sim{sch} from library lab1
*** Created on Thu Sep 24, 2026 19:42:40
*** Last revised on Thu Sep 24, 2026 19:55:30
*** Written on Thu Sep 24, 2026 19:58:42 by Electric VLSI Design System, version 9.08
*** Layout tech: mocmos, foundry MOSIS
*** UC SPICE *** , MIN_RESIST 4.0, MIN_CAPAC 0.1FF

*** SUBCIRCUIT lab1__r_divider FROM CELL r_divider{sch}
.SUBCKT lab1__r_divider bot in out
Rresnwell@1 net@7 in 10k
Rresnwell@3 out bot 10k
Rresnwell@4 out net@7 10k
.ENDS lab1__r_divider

*** SUBCIRCUIT lab1__dac FROM CELL dac{sch}
.SUBCKT lab1__dac b0 b1 b2 b3 b4 vout
** GLOBAL gnd
Rresnwell@0 net@11 gnd 10k
Xr_divide@0 net@0 b4 vout lab1__r_divider
Xr_divide@1 net@1 b3 net@0 lab1__r_divider
Xr_divide@2 net@2 b2 net@1 lab1__r_divider
Xr_divide@3 net@3 b1 net@2 lab1__r_divider
Xr_divide@4 net@11 b0 net@3 lab1__r_divider
.ENDS lab1__dac

.global gnd

*** TOP LEVEL CELL: daq_sim{sch}
Ccap@0 gnd vout 10p
Xdac@0 net@40 gnd gnd gnd vin vout lab1__dac

* Spice Code nodes in cell cell 'daq_sim{sch}'
vin vin 0 pulse(0v 2v 1u 1f 1f 3u 6u)
.tran 0 2.4u 0 100p
.END
