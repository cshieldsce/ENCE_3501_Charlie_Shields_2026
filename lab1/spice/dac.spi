*** SPICE deck for cell dac{sch} from library lab1
*** Created on Thu Sep 24, 2026 19:33:41
*** Last revised on Thu Sep 24, 2026 19:40:08
*** Written on Thu Sep 24, 2026 19:41:27 by Electric VLSI Design System, version 9.08
*** Layout tech: mocmos, foundry MOSIS
*** UC SPICE *** , MIN_RESIST 4.0, MIN_CAPAC 0.1FF

*** SUBCIRCUIT lab1__r_divider FROM CELL r_divider{sch}
.SUBCKT lab1__r_divider bot in out
Rresnwell@1 net@7 in 10k
Rresnwell@3 out bot 10k
Rresnwell@4 out net@7 10k
.ENDS lab1__r_divider

.global gnd

*** TOP LEVEL CELL: dac{sch}
Rresnwell@0 net@11 gnd 10k
Xr_divide@0 net@0 b4 vout lab1__r_divider
Xr_divide@1 net@1 b3 net@0 lab1__r_divider
Xr_divide@2 net@2 b2 net@1 lab1__r_divider
Xr_divide@3 net@3 b1 net@2 lab1__r_divider
Xr_divide@4 net@11 b0 net@3 lab1__r_divider

* Spice Code nodes in cell cell 'dac{sch}'
v4 b4 0
v3 b3 0
v2 b2 0
v1 b1 b0
vin b0 0 DC 5
.op
.END
