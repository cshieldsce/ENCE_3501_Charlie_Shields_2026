*** SPICE deck for cell nmos{sch} from library Tutorial_3
*** Created on Mon Sep 28, 2026 11:32:50
*** Last revised on Mon Sep 28, 2026 11:42:31
*** Written on Mon Sep 28, 2026 11:43:51 by Electric VLSI Design System, version 9.08
*** Layout tech: mocmos, foundry MOSIS
*** UC SPICE *** , MIN_RESIST 4.0, MIN_CAPAC 0.1FF

.global gnd

*** TOP LEVEL CELL: nmos{sch}
Mnmos-4@0 D G S gnd NMOS L=0.4U W=2U

* Spice Code nodes in cell cell 'nmos{sch}'
vd D 0 DC 0
vg G 0 DC 0
vc S 0 DC 0
.dc vd 0 5 1m vg 0 5 1
.include C5_models.txt
.END
